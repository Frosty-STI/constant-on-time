Constant On-Time Lab -- Stage 11 capstone behavioral test bench
* Two mismatched phases, adaptive on-time, fixed eligibility windows,
* per-phase current limit, low-bandwidth current balance, phase shedding,
* dead time, load steps, and line steps. This is a generic educational model.
.INC "pspice/lib/BUCK_PHASE.lib"
.INC "pspice/lib/COT_ONESHOT.lib"
.INC "pspice/lib/COT_CONTROLLER.lib"
.INC "pspice/lib/CURRENT_BALANCE.lib"
.INC "pspice/lib/PHASE_SHEDDING.lib"
.PARAM VREF_DC=5 TPER=2u TONMIN=100n TONMAX=1.5u
VIN IN 0 PWL(0 12 800u 12 801u 9 1.4m 9 1.401m 12 2m 12)
VREF REF 0 PWL(0 0 5u 0 6u {VREF_DC})
VRIPPLE RIPPLE 0 0
VILIM ILIM 0 8
VFORCE FORCE 0 0
* Dynamic load command: light -> heavy -> light -> medium. LOADEN makes the
* ideal current sink explicitly inactive at 0 V during initial controller
* enable; LOADACT is the actual current used by both the plant and shed logic.
VLOADMON LOADMON 0 PWL(0 1 300u 1 301u 8 700u 8
+ 701u 2 1.6m 2 1.601m 6 2m 6)
VLOADEN LOADEN 0 PWL(0 0 20u 0 100u 1 2m 1)
ELOADACT LOADACT 0 VALUE={V(LOADMON)*V(LOADEN)}
GLOAD OUT 0 VALUE={V(LOADACT)}
XSHED LOADACT FORCE ACTIVE2 SHEDSTATE PHASE_SHEDDING_2 PARAMS:
+ ISHED=2.5 IADD=3.5 TRAMP=20u VLOGIC=1
* Current-balance trims shift each phase's local comparator observation.
ESENSE1 SENSE1 0 VALUE={1.01*V(IMON1)+10m}
ESENSE2 SENSE2 0 VALUE={0.99*V(IMON2)-10m}
XBAL SENSE1 SENSE2 ACTIVE2 TRIM1 TRIM2 SHAREERR CURRENT_BALANCE_2 PARAMS:
+ BW=2k KBAL=25m TRIMMAX=75m VLOGIC=1
EFB1 FB1 0 VALUE={V(OUT)+V(TRIM1)}
EFB2 FB2 0 VALUE={V(OUT)+V(TRIM2)}
XREQ1 FB1 REF RIPPLE REQC1 COT_REQUEST PARAMS:
+ VLOGIC=5 VSOFT=2m VHYST=4m TDELAY=12n
XREQ2 FB2 REF RIPPLE REQC2 COT_REQUEST PARAMS:
+ VLOGIC=5 VSOFT=2m VHYST=4m TDELAY=16n
* Representative adaptive feed-forward law. TONMON uses 1 V/s.
ETON TONMON 0 VALUE={LIMIT(TPER*V(REF)/IF(V(IN)>1,V(IN),1),
+ TONMIN,TONMAX)}
* Fixed eligibility windows prevent simultaneous requests in this architecture.
VPERMIT1 PERMIT1 0 PULSE(1 0 900n 1n 1n 1.098u {TPER})
VPERMIT2 PERMIT2 0 PULSE(0 1 1u 1n 1n 900n {TPER})
EREQ1 REQ1 0 VALUE={V(REQC1)*V(PERMIT1)}
EREQ2 REQ2 0 VALUE={V(REQC2)*V(PERMIT2)*V(ACTIVE2)}
XCL1 SENSE1 ILIM TRIP1 COT_CURRENT_LIMIT PARAMS:
+ VLOGIC=5 TDELAY=8n
XCL2 SENSE2 ILIM TRIP2 COT_CURRENT_LIMIT PARAMS:
+ VLOGIC=5 TDELAY=10n
XSHOT1 REQ1 TRIP1 TONMON GATE1 READY1 COT_ONESHOT_CMD PARAMS:
+ TONMIN={TONMIN} TONMAX={TONMAX} TOFFMIN=100n VLOGIC=5
XSHOT2 REQ2 TRIP2 TONMON GATE2 READY2 COT_ONESHOT_CMD PARAMS:
+ TONMIN={TONMIN} TONMAX={TONMAX} TOFFMIN=100n VLOGIC=5
XDRV1 GATE1 GH1 GL1 COMPLEMENTARY_DRIVER PARAMS: VLOGIC=5 DEAD=20n
* Phase shedding gates both switches off; PWM=0 alone would turn the
* synchronous low-side switch on and incorrectly load the shared output.
XDRV2 GATE2 ACTIVE2 GH2 GL2 COMPLEMENTARY_DRIVER_ENABLE PARAMS:
+ VLOGIC=5 VENHIGH=1 DEAD=25n
XPH1 IN OUT GH1 GL1 SW1 IMON1 BUCK_PHASE PARAMS:
+ LPH=1.9u DCR=9m RHS=14m RLS=8m IMONGAIN=1
XPH2 IN OUT GH2 GL2 SW2 IMON2 BUCK_PHASE PARAMS:
+ LPH=2.1u DCR=12m RHS=17m RLS=9m IMONGAIN=1
RESR OUT NCAP 8m
COUT NCAP 0 470u IC=0
RBLEED OUT 0 100
EISUM ISUM 0 VALUE={V(IMON1)+V(IMON2)}
* Include the explicit bleed branch so ICAPMON matches output-node KCL.
ECAPCURRENT ICAPMON 0 VALUE={V(ISUM)-V(LOADACT)-V(OUT)/100}
.IC V(OUT)=0
.OPTIONS RELTOL=1m ABSTOL=10n VNTOL=1u ITL4=2500
.TRAN 5n 2m 0 5n
.MEAS TRAN STARTUP_MAX MAX V(OUT) FROM=0 TO=300u
.MEAS TRAN LOADSTEP_MIN MIN V(OUT) FROM=301u TO=500u
.MEAS TRAN LINESTEP_MIN MIN V(OUT) FROM=801u TO=1m
.MEAS TRAN FINAL_VOUT AVG V(OUT) FROM=1.9m TO=2m
.MEAS TRAN FINAL_SHARE AVG V(SHAREERR) FROM=1.9m TO=2m
.PROBE V(IN) V(OUT) V(NCAP) V(LOADMON) V(LOADEN) V(LOADACT) V(TONMON)
+ V(IMON1) V(IMON2) V(SENSE1) V(SENSE2) V(ISUM) V(ICAPMON)
+ V(SW1) V(SW2) V(GATE1) V(GATE2) V(GH1) V(GL1) V(GH2) V(GL2)
+ V(REQC1) V(REQC2) V(REQ1) V(REQ2) V(TRIP1) V(TRIP2)
+ V(READY1) V(READY2) V(PERMIT1) V(PERMIT2)
+ V(ACTIVE2) V(SHEDSTATE) V(TRIM1) V(TRIM2) V(SHAREERR)
.END
