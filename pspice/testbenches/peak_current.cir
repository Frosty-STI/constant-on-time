Constant On-Time Lab -- Stage 5: simplified peak-current-mode controller
.INC "pspice/lib/BUCK_PHASE.lib"
.INC "pspice/lib/COT_ONESHOT.lib"
.INC "pspice/lib/PEAK_CURRENT_CONTROLLER.lib"
.PARAM VIN_DC=12 FSW=500k TPER={1/FSW} VRAMP_PK=0.25
VIN IN 0 {VIN_DC}
VREF REF 0 PWL(0 0 5u 0 6u 5)
VENABLE ENABLE 0 PWL(0 0 5u 0 6u 1)
VCLOCKRAW CLOCKRAW 0 PULSE(0 5 0 1n 1n 20n {TPER})
ECLOCK CLOCK 0 VALUE={V(CLOCKRAW)*V(ENABLE)}
VBLANK BLANK 0 PULSE(5 0 60n 1n 1n {TPER-65n} {TPER})
VRAMP RAMP 0 PULSE(0 {VRAMP_PK} 0 {TPER-5n} 1n 1n {TPER})
XEA OUT REF VCMD GM_ERROR_AMP PARAMS:
+ GM=200u CCOMP=100n RLEAK=1MEG VMIN=0.1 VMAX=2
EISENSE ISENSE 0 VALUE={0.15*V(IMON)}
XPCM CLOCK VCMD ISENSE RAMP BLANK GATE TRIP READY
+ PEAK_CURRENT_CONTROLLER PARAMS: TMAX=1.8u TOFFMIN=20n VLOGIC=5
XDRV GATE GHS GLS COMPLEMENTARY_DRIVER PARAMS: VLOGIC=5 DEAD=20n
XPH IN OUT GHS GLS SW IMON BUCK_PHASE PARAMS:
+ LPH=2u DCR=10m RHS=15m RLS=8m
RESR OUT NCAP 8m
COUT NCAP 0 220u IC=0
RLOAD OUT 0 1
RBLEED OUT 0 100
.IC V(OUT)=0
.OPTIONS RELTOL=1m ABSTOL=10n VNTOL=1u ITL4=1000
.TRAN 5n 2m 0 5n
.MEAS TRAN VOUT_AVG AVG V(OUT) FROM=1.8m TO=2m
.MEAS TRAN IPEAK MAX V(IMON) FROM=1.8m TO=2m
.PROBE V(OUT) V(SW) V(IMON) V(ISENSE) V(VCMD) V(RAMP)
+ V(CLOCKRAW) V(CLOCK) V(ENABLE) V(BLANK) V(TRIP) V(GATE)
.END
