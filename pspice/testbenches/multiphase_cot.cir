Constant On-Time Lab -- Stage 8: generated-style four-phase COT model
* Regenerate arbitrary 2..8 phase decks with pspice/scripts/generate_multiphase.py.
.INC "pspice/lib/BUCK_PHASE.lib"
.INC "pspice/lib/COT_ONESHOT.lib"
.INC "pspice/lib/COT_CONTROLLER.lib"
.PARAM VIN_DC=12 VREF_DC=5 TPER=2u TON={TPER*VREF_DC/VIN_DC}
VIN IN 0 {VIN_DC}
VREF REF 0 PWL(0 0 5u 0 6u {VREF_DC})
VRIPPLE RIPPLE 0 0
VILIM ILIM 0 5
XCMP OUT REF RIPPLE REQCOMMON COT_REQUEST PARAMS:
+ VLOGIC=5 VSOFT=2m VHYST=4m TDELAY=10n
VPERMIT1 PERMIT1 0 PULSE(1 0 350n 1n 1n 1.648u {TPER})
VPERMIT2 PERMIT2 0 PULSE(0 1 500n 1n 1n 350n {TPER})
VPERMIT3 PERMIT3 0 PULSE(0 1 1u 1n 1n 350n {TPER})
VPERMIT4 PERMIT4 0 PULSE(0 1 1.5u 1n 1n 350n {TPER})
EREQ1 REQ1 0 VALUE={V(REQCOMMON)*V(PERMIT1)}
EREQ2 REQ2 0 VALUE={V(REQCOMMON)*V(PERMIT2)}
EREQ3 REQ3 0 VALUE={V(REQCOMMON)*V(PERMIT3)}
EREQ4 REQ4 0 VALUE={V(REQCOMMON)*V(PERMIT4)}
XCL1 IMON1 ILIM TRIP1 COT_CURRENT_LIMIT PARAMS: VLOGIC=5
XCL2 IMON2 ILIM TRIP2 COT_CURRENT_LIMIT PARAMS: VLOGIC=5
XCL3 IMON3 ILIM TRIP3 COT_CURRENT_LIMIT PARAMS: VLOGIC=5
XCL4 IMON4 ILIM TRIP4 COT_CURRENT_LIMIT PARAMS: VLOGIC=5
XSHOT1 REQ1 TRIP1 GATE1 READY1 COT_ONESHOT PARAMS:
+ TON={TON} TOFFMIN=100n VLOGIC=5
XSHOT2 REQ2 TRIP2 GATE2 READY2 COT_ONESHOT PARAMS:
+ TON={TON} TOFFMIN=100n VLOGIC=5
XSHOT3 REQ3 TRIP3 GATE3 READY3 COT_ONESHOT PARAMS:
+ TON={TON} TOFFMIN=100n VLOGIC=5
XSHOT4 REQ4 TRIP4 GATE4 READY4 COT_ONESHOT PARAMS:
+ TON={TON} TOFFMIN=100n VLOGIC=5
XDRV1 GATE1 GH1 GL1 COMPLEMENTARY_DRIVER PARAMS: VLOGIC=5 DEAD=20n
XDRV2 GATE2 GH2 GL2 COMPLEMENTARY_DRIVER PARAMS: VLOGIC=5 DEAD=20n
XDRV3 GATE3 GH3 GL3 COMPLEMENTARY_DRIVER PARAMS: VLOGIC=5 DEAD=20n
XDRV4 GATE4 GH4 GL4 COMPLEMENTARY_DRIVER PARAMS: VLOGIC=5 DEAD=20n
XPH1 IN OUT GH1 GL1 SW1 IMON1 BUCK_PHASE PARAMS: LPH=2u DCR=10m
XPH2 IN OUT GH2 GL2 SW2 IMON2 BUCK_PHASE PARAMS: LPH=2u DCR=10m
XPH3 IN OUT GH3 GL3 SW3 IMON3 BUCK_PHASE PARAMS: LPH=2u DCR=10m
XPH4 IN OUT GH4 GL4 SW4 IMON4 BUCK_PHASE PARAMS: LPH=2u DCR=10m
EISUM ISUM 0 VALUE={V(IMON1)+V(IMON2)+V(IMON3)+V(IMON4)}
RESR OUT NCAP 5m
COUT NCAP 0 470u IC=0
RLOAD OUT 0 312.5m
RBLEED OUT 0 100
.IC V(OUT)=0
.OPTIONS RELTOL=1m ABSTOL=10n VNTOL=1u ITL4=2000
.TRAN 5n 2m 0 5n
.MEAS TRAN VOUT_AVG AVG V(OUT) FROM=1.8m TO=2m
.MEAS TRAN ISUM_AVG AVG V(ISUM) FROM=1.8m TO=2m
.MEAS TRAN ISUM_PP PP V(ISUM) FROM=1.8m TO=2m
.PROBE V(OUT) V(ISUM) V(IMON1) V(IMON2) V(IMON3) V(IMON4)
+ V(SW1) V(SW2) V(SW3) V(SW4)
+ V(GATE1) V(GATE2) V(GATE3) V(GATE4)
.END
