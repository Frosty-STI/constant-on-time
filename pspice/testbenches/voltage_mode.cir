Constant On-Time Lab -- Stage 4: generic fixed-frequency voltage-mode loop
.INC "pspice/lib/BUCK_PHASE.lib"
.PARAM VIN_DC=12 FSW=500k TPER={1/FSW}
VIN IN 0 {VIN_DC}
VREF REF 0 PWL(0 0 5u 0 6u 5)
VENABLE ENABLE 0 PWL(0 0 5u 0 6u 1)
* Sawtooth is 0..1 V. The error-amplifier output is therefore duty command.
VRAMP RAMP 0 PULSE(0 1 0 {TPER-5n} 1n 1n {TPER})
GERR 0 COMP VALUE={150u*(V(REF)-V(OUT))}
CCOMP COMP 0 100n IC=50m
RCOMP COMP 0 1MEG
ECTRL CTRL 0 VALUE={LIMIT(V(COMP),0.03,0.92)}
EPWM PWM 0 VALUE={IF(V(ENABLE)>0.5,
+ IF(V(CTRL)>V(RAMP),5,0),0)}
EDUTYMON DUTYMON 0 VALUE={V(PWM)/5}
XDRV PWM GHS GLS COMPLEMENTARY_DRIVER PARAMS: VLOGIC=5 DEAD=20n
XPH IN OUT GHS GLS SW IMON BUCK_PHASE PARAMS:
+ LPH=2u DCR=10m RHS=15m RLS=8m
RESR OUT NCAP 8m
COUT NCAP 0 220u IC=0
RLOAD OUT 0 1
RBLEED OUT 0 100
.IC V(OUT)=0 V(COMP)=50m
.OPTIONS RELTOL=1m ABSTOL=10n VNTOL=1u ITL4=1000
.TRAN 5n 2m 0 5n
.MEAS TRAN VOUT_AVG AVG V(OUT) FROM=1.8m TO=2m
.MEAS TRAN DUTY_AVG AVG V(DUTYMON) FROM=1.8m TO=2m
.PROBE V(OUT) V(SW) V(IMON) V(COMP) V(RAMP) V(ENABLE)
+ V(PWM) V(DUTYMON)
.END
