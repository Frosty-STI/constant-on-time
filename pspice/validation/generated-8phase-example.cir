Constant On-Time Lab -- generated 8-phase fixed-window COT deck
* Generated by pspice/scripts/generate_multiphase.py.
* Educational behavioral architecture; not a commercial-controller model.
.INC "pspice/lib/BUCK_PHASE.lib"
.INC "pspice/lib/COT_ONESHOT.lib"
.INC "pspice/lib/COT_CONTROLLER.lib"
.PARAM VIN_DC=12 VREF_DC=5
.PARAM TPER=2u TON=833.333333n
VIN IN 0 {VIN_DC}
VREF REF 0 PWL(0 0 5u 0 6u {VREF_DC})
VRIPPLE RIPPLE 0 0
VILIM ILIM 0 6
XCMP OUT REF RIPPLE REQCOMMON COT_REQUEST PARAMS:
+ VLOGIC=5 VSOFT=2m VHYST=4m TDELAY=10n
VPERMIT1 PERMIT1 0 PULSE(1 0 175n 1n 1n 1.823u 2u)
VPERMIT2 PERMIT2 0 PULSE(0 1 250n 1n 1n 175n 2u)
VPERMIT3 PERMIT3 0 PULSE(0 1 500n 1n 1n 175n 2u)
VPERMIT4 PERMIT4 0 PULSE(0 1 750n 1n 1n 175n 2u)
VPERMIT5 PERMIT5 0 PULSE(0 1 1u 1n 1n 175n 2u)
VPERMIT6 PERMIT6 0 PULSE(0 1 1.25u 1n 1n 175n 2u)
VPERMIT7 PERMIT7 0 PULSE(0 1 1.5u 1n 1n 175n 2u)
VPERMIT8 PERMIT8 0 PULSE(0 1 1.75u 1n 1n 175n 2u)
* Windows serialize requests, but phase power pulses may overlap.
EREQ1 REQ1 0 VALUE={V(REQCOMMON)*V(PERMIT1)}
XCL1 IMON1 ILIM TRIP1 COT_CURRENT_LIMIT PARAMS: VLOGIC=5
XSHOT1 REQ1 TRIP1 GATE1 READY1 COT_ONESHOT PARAMS:
+ TON={TON} TOFFMIN=100n VLOGIC=5
XDRV1 GATE1 GH1 GL1 COMPLEMENTARY_DRIVER PARAMS:
+ VLOGIC=5 DEAD=20n
XPH1 IN OUT GH1 GL1 SW1 IMON1 BUCK_PHASE PARAMS:
+ LPH=1.86u DCR=11.05m RHS=15m RLS=8m
EREQ2 REQ2 0 VALUE={V(REQCOMMON)*V(PERMIT2)}
XCL2 IMON2 ILIM TRIP2 COT_CURRENT_LIMIT PARAMS: VLOGIC=5
XSHOT2 REQ2 TRIP2 GATE2 READY2 COT_ONESHOT PARAMS:
+ TON={TON} TOFFMIN=100n VLOGIC=5
XDRV2 GATE2 GH2 GL2 COMPLEMENTARY_DRIVER PARAMS:
+ VLOGIC=5 DEAD=20n
XPH2 IN OUT GH2 GL2 SW2 IMON2 BUCK_PHASE PARAMS:
+ LPH=1.9u DCR=10.75m RHS=15m RLS=8m
EREQ3 REQ3 0 VALUE={V(REQCOMMON)*V(PERMIT3)}
XCL3 IMON3 ILIM TRIP3 COT_CURRENT_LIMIT PARAMS: VLOGIC=5
XSHOT3 REQ3 TRIP3 GATE3 READY3 COT_ONESHOT PARAMS:
+ TON={TON} TOFFMIN=100n VLOGIC=5
XDRV3 GATE3 GH3 GL3 COMPLEMENTARY_DRIVER PARAMS:
+ VLOGIC=5 DEAD=20n
XPH3 IN OUT GH3 GL3 SW3 IMON3 BUCK_PHASE PARAMS:
+ LPH=1.94u DCR=10.45m RHS=15m RLS=8m
EREQ4 REQ4 0 VALUE={V(REQCOMMON)*V(PERMIT4)}
XCL4 IMON4 ILIM TRIP4 COT_CURRENT_LIMIT PARAMS: VLOGIC=5
XSHOT4 REQ4 TRIP4 GATE4 READY4 COT_ONESHOT PARAMS:
+ TON={TON} TOFFMIN=100n VLOGIC=5
XDRV4 GATE4 GH4 GL4 COMPLEMENTARY_DRIVER PARAMS:
+ VLOGIC=5 DEAD=20n
XPH4 IN OUT GH4 GL4 SW4 IMON4 BUCK_PHASE PARAMS:
+ LPH=1.98u DCR=10.15m RHS=15m RLS=8m
EREQ5 REQ5 0 VALUE={V(REQCOMMON)*V(PERMIT5)}
XCL5 IMON5 ILIM TRIP5 COT_CURRENT_LIMIT PARAMS: VLOGIC=5
XSHOT5 REQ5 TRIP5 GATE5 READY5 COT_ONESHOT PARAMS:
+ TON={TON} TOFFMIN=100n VLOGIC=5
XDRV5 GATE5 GH5 GL5 COMPLEMENTARY_DRIVER PARAMS:
+ VLOGIC=5 DEAD=20n
XPH5 IN OUT GH5 GL5 SW5 IMON5 BUCK_PHASE PARAMS:
+ LPH=2.02u DCR=9.85m RHS=15m RLS=8m
EREQ6 REQ6 0 VALUE={V(REQCOMMON)*V(PERMIT6)}
XCL6 IMON6 ILIM TRIP6 COT_CURRENT_LIMIT PARAMS: VLOGIC=5
XSHOT6 REQ6 TRIP6 GATE6 READY6 COT_ONESHOT PARAMS:
+ TON={TON} TOFFMIN=100n VLOGIC=5
XDRV6 GATE6 GH6 GL6 COMPLEMENTARY_DRIVER PARAMS:
+ VLOGIC=5 DEAD=20n
XPH6 IN OUT GH6 GL6 SW6 IMON6 BUCK_PHASE PARAMS:
+ LPH=2.06u DCR=9.55m RHS=15m RLS=8m
EREQ7 REQ7 0 VALUE={V(REQCOMMON)*V(PERMIT7)}
XCL7 IMON7 ILIM TRIP7 COT_CURRENT_LIMIT PARAMS: VLOGIC=5
XSHOT7 REQ7 TRIP7 GATE7 READY7 COT_ONESHOT PARAMS:
+ TON={TON} TOFFMIN=100n VLOGIC=5
XDRV7 GATE7 GH7 GL7 COMPLEMENTARY_DRIVER PARAMS:
+ VLOGIC=5 DEAD=20n
XPH7 IN OUT GH7 GL7 SW7 IMON7 BUCK_PHASE PARAMS:
+ LPH=2.1u DCR=9.25m RHS=15m RLS=8m
EREQ8 REQ8 0 VALUE={V(REQCOMMON)*V(PERMIT8)}
XCL8 IMON8 ILIM TRIP8 COT_CURRENT_LIMIT PARAMS: VLOGIC=5
XSHOT8 REQ8 TRIP8 GATE8 READY8 COT_ONESHOT PARAMS:
+ TON={TON} TOFFMIN=100n VLOGIC=5
XDRV8 GATE8 GH8 GL8 COMPLEMENTARY_DRIVER PARAMS:
+ VLOGIC=5 DEAD=20n
XPH8 IN OUT GH8 GL8 SW8 IMON8 BUCK_PHASE PARAMS:
+ LPH=2.14u DCR=8.95m RHS=15m RLS=8m
EISUM ISUM 0 VALUE={V(IMON1)+V(IMON2)+V(IMON3)+V(IMON4)+V(IMON5)+V(IMON6)+V(IMON7)+V(IMON8)}
RESR OUT NCAP 5m
COUT NCAP 0 470u IC=0
* Resistive equivalent draws the requested load at target VOUT
RLOAD OUT 0 312.5m
RBLEED OUT 0 100
.IC V(OUT)=0
.OPTIONS RELTOL=1m ABSTOL=10n VNTOL=1u ITL4=2500
.TRAN 5n 2m 0 5n
.MEAS TRAN VOUT_AVG AVG V(OUT) FROM=1.8m TO=2m
.MEAS TRAN ISUM_AVG AVG V(ISUM) FROM=1.8m TO=2m
.PROBE V(OUT) V(ISUM) V(IMON1) V(IMON2) V(IMON3) V(IMON4) V(IMON5) V(IMON6) V(IMON7) V(IMON8)
+ V(SW1) V(SW2) V(SW3) V(SW4) V(SW5) V(SW6) V(SW7) V(SW8)
+ V(GATE1) V(GATE2) V(GATE3) V(GATE4) V(GATE5) V(GATE6) V(GATE7) V(GATE8)
.END
