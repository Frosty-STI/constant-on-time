Constant On-Time Lab -- Stage 6: single-phase fixed-on-time controller
.INC "pspice/lib/BUCK_PHASE.lib"
.INC "pspice/lib/COT_ONESHOT.lib"
.INC "pspice/lib/COT_CONTROLLER.lib"
.PARAM VIN_DC=12 VREF_DC=5 FSW_NOM=500k TPER={1/FSW_NOM}
.PARAM TON_NOM={TPER*VREF_DC/VIN_DC}
VIN IN 0 {VIN_DC}
VREF REF 0 PWL(0 0 5u 0 6u {VREF_DC})
VRIPPLE RIPPLE 0 0
EISENSE ISENSE 0 VALUE={V(IMON)}
XCOT OUT REF RIPPLE ISENSE GATE REQUEST READY COT_CONTROLLER PARAMS:
+ TON={TON_NOM} TONMIN=100n TONMAX=1.5u TOFFMIN=100n
+ ILIMIT=12 VLOGIC=5 VSOFT=2m VHYST=4m TDELAY=10n
XDRV GATE GHS GLS COMPLEMENTARY_DRIVER PARAMS: VLOGIC=5 DEAD=20n
XPH IN OUT GHS GLS SW IMON BUCK_PHASE PARAMS:
+ LPH=2u DCR=10m RHS=15m RLS=8m
* ESR is intentionally present: OUT includes natural capacitor-current ripple.
RESR OUT NCAP 12m
COUT NCAP 0 220u IC=0
RLOAD OUT 0 1
RBLEED OUT 0 100
.IC V(OUT)=0
.OPTIONS RELTOL=1m ABSTOL=10n VNTOL=1u ITL4=1200
.TRAN 5n 2m 0 5n
.MEAS TRAN VOUT_AVG AVG V(OUT) FROM=1.8m TO=2m
.MEAS TRAN VOUT_PP PP V(OUT) FROM=1.8m TO=2m
.MEAS TRAN TSW TRIG V(GATE) VAL=2.5 RISE=700
+ TARG V(GATE) VAL=2.5 RISE=701
.PROBE V(OUT) V(NCAP) V(SW) V(IMON) V(REQUEST) V(READY)
+ V(GATE) V(GHS) V(GLS)
.END
