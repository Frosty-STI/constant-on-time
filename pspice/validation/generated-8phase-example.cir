Constant On-Time Lab -- generated 8-phase cumulative COT capstone
* Generated by pspice/scripts/generate_multiphase.py.
* Educational behavioral architecture; not a commercial-controller model.
* STRUCTURAL/ANALYTICAL REVIEW ONLY: Cadence PSpice execution NOT RUN.
* Scheduler=fixed-window; permit-slot-skew=3 ns;
* on-time-law=adaptive; balance=on; phase-shedding=on.
* One volt on TONBASE/TONCMD represents one second of commanded on-time.
.INC "pspice/lib/BUCK_PHASE.lib"
.INC "pspice/lib/COT_ONESHOT.lib"
.INC "pspice/lib/COT_CONTROLLER.lib"
.INC "pspice/lib/CURRENT_BALANCE.lib"
.INC "pspice/lib/PHASE_SHEDDING.lib"
.PARAM NPHASES=8 VIN_NOM=12 VREF_DC=5
.PARAM FSW=500000 TPER=2u TONFIX=833.333333n
.PARAM TONMIN=100n TONMAX=1.5u TOFFMIN=100n
.PARAM BAL_BW=2000 BAL_GAIN=0.025 BAL_TRIM=0.075
VIN IN 0 PWL(0 12 1m 12 1.000001m 9 1.3m 9 1.300001m 12 2m 12)
VREF REF 0 PWL(0 0 20u 0 40u {VREF_DC} 2m {VREF_DC})
VCTRLEN CTRLEN 0 PWL(0 0 20u 0 20.001u 1 2m 1)
VRIPPLE RIPPLE 0 SIN(0 8m {FSW} 0 0 45)
VILIM ILIM 0 6
VFORCEON FORCEON 0 0
* LOADCMD is 1 V/A. LOADEN prevents an ideal current sink at zero output.
VLOADCMD LOADCMD 0 PWL(0 2 400u 2 400.001u 24 800u 24 800.001u 2 2m 2)
VLOADEN LOADEN 0 PWL(0 0 41u 0 51u 1 2m 1)
ELOADACT LOADACT 0 VALUE={V(LOADCMD)*V(LOADEN)}
GLOAD OUT 0 VALUE={V(LOADACT)}
* Representative feed-forward adaptive law; not universal COT behavior.
ETONBASE TONBASE 0 VALUE={LIMIT(TPER*V(REF)/
+ IF(V(IN)>1,V(IN),1),TONMIN,TONMAX)}
* ACTIVE1 is mandatory; later phases use staged hysteretic shedding.
VACTIVE1 ACTIVE1 0 1
XSHED2 LOADACT FORCEON ACTIVE2 SHEDSTATE2 PHASE_SHEDDING_2 PARAMS:
+ ISHED=2.5 IADD=3 TRAMP=20u VLOGIC=1
XSHED3 LOADACT FORCEON ACTIVE3 SHEDSTATE3 PHASE_SHEDDING_2 PARAMS:
+ ISHED=5.5 IADD=6 TRAMP=20u VLOGIC=1
XSHED4 LOADACT FORCEON ACTIVE4 SHEDSTATE4 PHASE_SHEDDING_2 PARAMS:
+ ISHED=8.5 IADD=9 TRAMP=20u VLOGIC=1
XSHED5 LOADACT FORCEON ACTIVE5 SHEDSTATE5 PHASE_SHEDDING_2 PARAMS:
+ ISHED=11.5 IADD=12 TRAMP=20u VLOGIC=1
XSHED6 LOADACT FORCEON ACTIVE6 SHEDSTATE6 PHASE_SHEDDING_2 PARAMS:
+ ISHED=14.5 IADD=15 TRAMP=20u VLOGIC=1
XSHED7 LOADACT FORCEON ACTIVE7 SHEDSTATE7 PHASE_SHEDDING_2 PARAMS:
+ ISHED=17.5 IADD=18 TRAMP=20u VLOGIC=1
XSHED8 LOADACT FORCEON ACTIVE8 SHEDSTATE8 PHASE_SHEDDING_2 PARAMS:
+ ISHED=20.5 IADD=21 TRAMP=20u VLOGIC=1
VPERMIT1 PERMIT1 0 PULSE(0 1 1.997u 1n 1n 175n 2u)
VPERMIT2 PERMIT2 0 PULSE(0 1 247.857143n 1n 1n 175n 2u)
VPERMIT3 PERMIT3 0 PULSE(0 1 498.714286n 1n 1n 175n 2u)
VPERMIT4 PERMIT4 0 PULSE(0 1 749.571429n 1n 1n 175n 2u)
VPERMIT5 PERMIT5 0 PULSE(0 1 1.00042857u 1n 1n 175n 2u)
VPERMIT6 PERMIT6 0 PULSE(0 1 1.25128571u 1n 1n 175n 2u)
VPERMIT7 PERMIT7 0 PULSE(0 1 1.50214286u 1n 1n 175n 2u)
VPERMIT8 PERMIT8 0 PULSE(0 1 1.753u 1n 1n 175n 2u)
* Fixed windows serialize request opportunities; power pulses can still overlap.
EACTIVECOUNT ACTIVECOUNT 0 VALUE={
+ V(ACTIVE1)+V(ACTIVE2)
+ +V(ACTIVE3)+V(ACTIVE4)
+ +V(ACTIVE5)+V(ACTIVE6)
+ +V(ACTIVE7)+V(ACTIVE8)
+ }
EISHAREAVG ISHAREAVG 0 VALUE={(
+ V(IAVG1)*V(ACTIVE1)+V(IAVG2)*V(ACTIVE2)
+ +V(IAVG3)*V(ACTIVE3)+V(IAVG4)*V(ACTIVE4)
+ +V(IAVG5)*V(ACTIVE5)+V(IAVG6)*V(ACTIVE6)
+ +V(IAVG7)*V(ACTIVE7)+V(IAVG8)*V(ACTIVE8)
+ )/IF(V(ACTIVECOUNT)>0.5,V(ACTIVECOUNT),1)}
XBAL1 SENSE1 ISHAREAVG ACTIVE1 IAVG1 TRIM1 SHAREERR1 CURRENT_BALANCE_CELL PARAMS:
+ BW={BAL_BW} KBAL={BAL_GAIN} TRIMMAX={BAL_TRIM} VLOGIC=1
XBAL2 SENSE2 ISHAREAVG ACTIVE2 IAVG2 TRIM2 SHAREERR2 CURRENT_BALANCE_CELL PARAMS:
+ BW={BAL_BW} KBAL={BAL_GAIN} TRIMMAX={BAL_TRIM} VLOGIC=1
XBAL3 SENSE3 ISHAREAVG ACTIVE3 IAVG3 TRIM3 SHAREERR3 CURRENT_BALANCE_CELL PARAMS:
+ BW={BAL_BW} KBAL={BAL_GAIN} TRIMMAX={BAL_TRIM} VLOGIC=1
XBAL4 SENSE4 ISHAREAVG ACTIVE4 IAVG4 TRIM4 SHAREERR4 CURRENT_BALANCE_CELL PARAMS:
+ BW={BAL_BW} KBAL={BAL_GAIN} TRIMMAX={BAL_TRIM} VLOGIC=1
XBAL5 SENSE5 ISHAREAVG ACTIVE5 IAVG5 TRIM5 SHAREERR5 CURRENT_BALANCE_CELL PARAMS:
+ BW={BAL_BW} KBAL={BAL_GAIN} TRIMMAX={BAL_TRIM} VLOGIC=1
XBAL6 SENSE6 ISHAREAVG ACTIVE6 IAVG6 TRIM6 SHAREERR6 CURRENT_BALANCE_CELL PARAMS:
+ BW={BAL_BW} KBAL={BAL_GAIN} TRIMMAX={BAL_TRIM} VLOGIC=1
XBAL7 SENSE7 ISHAREAVG ACTIVE7 IAVG7 TRIM7 SHAREERR7 CURRENT_BALANCE_CELL PARAMS:
+ BW={BAL_BW} KBAL={BAL_GAIN} TRIMMAX={BAL_TRIM} VLOGIC=1
XBAL8 SENSE8 ISHAREAVG ACTIVE8 IAVG8 TRIM8 SHAREERR8 CURRENT_BALANCE_CELL PARAMS:
+ BW={BAL_BW} KBAL={BAL_GAIN} TRIMMAX={BAL_TRIM} VLOGIC=1
* Phase 1: normalized mismatch position -1.000000.
ESENSE1 SENSE1 0 VALUE={0.985*V(IMON1)-0.012}
EFB1 FB1 0 VALUE={V(OUT)+V(TRIM1)}
XREQ1 FB1 REF RIPPLE REQC1 COT_REQUEST PARAMS:
+ VLOGIC=5 VSOFT=2m VHYST=4m TDELAY=9.8n
EPHASEEN1 PHASEEN1 0 VALUE={V(CTRLEN)*V(ACTIVE1)}
EREQ1 REQ1 0 VALUE={V(REQC1)*V(PERMIT1)*V(PHASEEN1)}
EDENIED1 DENIED1 0 VALUE={V(REQC1)*
+ (1-V(PERMIT1)*V(PHASEEN1))}
XCL1 SENSE1 ILIM TRIP1 COT_CURRENT_LIMIT PARAMS:
+ VLOGIC=5 TDELAY=7.84n
ETON1 TONCMD1 0 VALUE={LIMIT(V(TONBASE)*0.98,
+ TONMIN,TONMAX)}
XSHOT1 REQ1 TRIP1 TONCMD1 GATE1 READY1 COT_ONESHOT_CMD PARAMS:
+ TONMIN={TONMIN} TONMAX={TONMAX} TOFFMIN={TOFFMIN} VLOGIC=5
XDRV1 GATE1 PHASEEN1 GH1 GL1 COMPLEMENTARY_DRIVER_ENABLE PARAMS:
+ VLOGIC=5 VENHIGH=1 DEAD=19.6n
XPH1 IN OUT GH1 GL1 SW1 IMON1 BUCK_PHASE PARAMS:
+ LPH=1.94u DCR=10.4m RHS=14.7m RLS=8.16m VBDROP=50m IMONGAIN=1
* Phase 2: normalized mismatch position -0.714286.
ESENSE2 SENSE2 0 VALUE={0.989285714*V(IMON2)-0.00857142857}
EFB2 FB2 0 VALUE={V(OUT)+V(TRIM2)}
XREQ2 FB2 REF RIPPLE REQC2 COT_REQUEST PARAMS:
+ VLOGIC=5 VSOFT=2m VHYST=4m TDELAY=9.85714286n
EPHASEEN2 PHASEEN2 0 VALUE={V(CTRLEN)*V(ACTIVE2)}
EREQ2 REQ2 0 VALUE={V(REQC2)*V(PERMIT2)*V(PHASEEN2)}
EDENIED2 DENIED2 0 VALUE={V(REQC2)*
+ (1-V(PERMIT2)*V(PHASEEN2))}
XCL2 SENSE2 ILIM TRIP2 COT_CURRENT_LIMIT PARAMS:
+ VLOGIC=5 TDELAY=7.88571429n
ETON2 TONCMD2 0 VALUE={LIMIT(V(TONBASE)*0.985714286,
+ TONMIN,TONMAX)}
XSHOT2 REQ2 TRIP2 TONCMD2 GATE2 READY2 COT_ONESHOT_CMD PARAMS:
+ TONMIN={TONMIN} TONMAX={TONMAX} TOFFMIN={TOFFMIN} VLOGIC=5
XDRV2 GATE2 PHASEEN2 GH2 GL2 COMPLEMENTARY_DRIVER_ENABLE PARAMS:
+ VLOGIC=5 VENHIGH=1 DEAD=19.7142857n
XPH2 IN OUT GH2 GL2 SW2 IMON2 BUCK_PHASE PARAMS:
+ LPH=1.95714286u DCR=10.2857143m RHS=14.7857143m RLS=8.11428571m VBDROP=50m IMONGAIN=1
* Phase 3: normalized mismatch position -0.428571.
ESENSE3 SENSE3 0 VALUE={0.993571429*V(IMON3)-0.00514285714}
EFB3 FB3 0 VALUE={V(OUT)+V(TRIM3)}
XREQ3 FB3 REF RIPPLE REQC3 COT_REQUEST PARAMS:
+ VLOGIC=5 VSOFT=2m VHYST=4m TDELAY=9.91428571n
EPHASEEN3 PHASEEN3 0 VALUE={V(CTRLEN)*V(ACTIVE3)}
EREQ3 REQ3 0 VALUE={V(REQC3)*V(PERMIT3)*V(PHASEEN3)}
EDENIED3 DENIED3 0 VALUE={V(REQC3)*
+ (1-V(PERMIT3)*V(PHASEEN3))}
XCL3 SENSE3 ILIM TRIP3 COT_CURRENT_LIMIT PARAMS:
+ VLOGIC=5 TDELAY=7.93142857n
ETON3 TONCMD3 0 VALUE={LIMIT(V(TONBASE)*0.991428571,
+ TONMIN,TONMAX)}
XSHOT3 REQ3 TRIP3 TONCMD3 GATE3 READY3 COT_ONESHOT_CMD PARAMS:
+ TONMIN={TONMIN} TONMAX={TONMAX} TOFFMIN={TOFFMIN} VLOGIC=5
XDRV3 GATE3 PHASEEN3 GH3 GL3 COMPLEMENTARY_DRIVER_ENABLE PARAMS:
+ VLOGIC=5 VENHIGH=1 DEAD=19.8285714n
XPH3 IN OUT GH3 GL3 SW3 IMON3 BUCK_PHASE PARAMS:
+ LPH=1.97428571u DCR=10.1714286m RHS=14.8714286m RLS=8.06857143m VBDROP=50m IMONGAIN=1
* Phase 4: normalized mismatch position -0.142857.
ESENSE4 SENSE4 0 VALUE={0.997857143*V(IMON4)-0.00171428571}
EFB4 FB4 0 VALUE={V(OUT)+V(TRIM4)}
XREQ4 FB4 REF RIPPLE REQC4 COT_REQUEST PARAMS:
+ VLOGIC=5 VSOFT=2m VHYST=4m TDELAY=9.97142857n
EPHASEEN4 PHASEEN4 0 VALUE={V(CTRLEN)*V(ACTIVE4)}
EREQ4 REQ4 0 VALUE={V(REQC4)*V(PERMIT4)*V(PHASEEN4)}
EDENIED4 DENIED4 0 VALUE={V(REQC4)*
+ (1-V(PERMIT4)*V(PHASEEN4))}
XCL4 SENSE4 ILIM TRIP4 COT_CURRENT_LIMIT PARAMS:
+ VLOGIC=5 TDELAY=7.97714286n
ETON4 TONCMD4 0 VALUE={LIMIT(V(TONBASE)*0.997142857,
+ TONMIN,TONMAX)}
XSHOT4 REQ4 TRIP4 TONCMD4 GATE4 READY4 COT_ONESHOT_CMD PARAMS:
+ TONMIN={TONMIN} TONMAX={TONMAX} TOFFMIN={TOFFMIN} VLOGIC=5
XDRV4 GATE4 PHASEEN4 GH4 GL4 COMPLEMENTARY_DRIVER_ENABLE PARAMS:
+ VLOGIC=5 VENHIGH=1 DEAD=19.9428571n
XPH4 IN OUT GH4 GL4 SW4 IMON4 BUCK_PHASE PARAMS:
+ LPH=1.99142857u DCR=10.0571429m RHS=14.9571429m RLS=8.02285714m VBDROP=50m IMONGAIN=1
* Phase 5: normalized mismatch position +0.142857.
ESENSE5 SENSE5 0 VALUE={1.00214286*V(IMON5)+0.00171428571}
EFB5 FB5 0 VALUE={V(OUT)+V(TRIM5)}
XREQ5 FB5 REF RIPPLE REQC5 COT_REQUEST PARAMS:
+ VLOGIC=5 VSOFT=2m VHYST=4m TDELAY=10.0285714n
EPHASEEN5 PHASEEN5 0 VALUE={V(CTRLEN)*V(ACTIVE5)}
EREQ5 REQ5 0 VALUE={V(REQC5)*V(PERMIT5)*V(PHASEEN5)}
EDENIED5 DENIED5 0 VALUE={V(REQC5)*
+ (1-V(PERMIT5)*V(PHASEEN5))}
XCL5 SENSE5 ILIM TRIP5 COT_CURRENT_LIMIT PARAMS:
+ VLOGIC=5 TDELAY=8.02285714n
ETON5 TONCMD5 0 VALUE={LIMIT(V(TONBASE)*1.00285714,
+ TONMIN,TONMAX)}
XSHOT5 REQ5 TRIP5 TONCMD5 GATE5 READY5 COT_ONESHOT_CMD PARAMS:
+ TONMIN={TONMIN} TONMAX={TONMAX} TOFFMIN={TOFFMIN} VLOGIC=5
XDRV5 GATE5 PHASEEN5 GH5 GL5 COMPLEMENTARY_DRIVER_ENABLE PARAMS:
+ VLOGIC=5 VENHIGH=1 DEAD=20.0571429n
XPH5 IN OUT GH5 GL5 SW5 IMON5 BUCK_PHASE PARAMS:
+ LPH=2.00857143u DCR=9.94285714m RHS=15.0428571m RLS=7.97714286m VBDROP=50m IMONGAIN=1
* Phase 6: normalized mismatch position +0.428571.
ESENSE6 SENSE6 0 VALUE={1.00642857*V(IMON6)+0.00514285714}
EFB6 FB6 0 VALUE={V(OUT)+V(TRIM6)}
XREQ6 FB6 REF RIPPLE REQC6 COT_REQUEST PARAMS:
+ VLOGIC=5 VSOFT=2m VHYST=4m TDELAY=10.0857143n
EPHASEEN6 PHASEEN6 0 VALUE={V(CTRLEN)*V(ACTIVE6)}
EREQ6 REQ6 0 VALUE={V(REQC6)*V(PERMIT6)*V(PHASEEN6)}
EDENIED6 DENIED6 0 VALUE={V(REQC6)*
+ (1-V(PERMIT6)*V(PHASEEN6))}
XCL6 SENSE6 ILIM TRIP6 COT_CURRENT_LIMIT PARAMS:
+ VLOGIC=5 TDELAY=8.06857143n
ETON6 TONCMD6 0 VALUE={LIMIT(V(TONBASE)*1.00857143,
+ TONMIN,TONMAX)}
XSHOT6 REQ6 TRIP6 TONCMD6 GATE6 READY6 COT_ONESHOT_CMD PARAMS:
+ TONMIN={TONMIN} TONMAX={TONMAX} TOFFMIN={TOFFMIN} VLOGIC=5
XDRV6 GATE6 PHASEEN6 GH6 GL6 COMPLEMENTARY_DRIVER_ENABLE PARAMS:
+ VLOGIC=5 VENHIGH=1 DEAD=20.1714286n
XPH6 IN OUT GH6 GL6 SW6 IMON6 BUCK_PHASE PARAMS:
+ LPH=2.02571429u DCR=9.82857143m RHS=15.1285714m RLS=7.93142857m VBDROP=50m IMONGAIN=1
* Phase 7: normalized mismatch position +0.714286.
ESENSE7 SENSE7 0 VALUE={1.01071429*V(IMON7)+0.00857142857}
EFB7 FB7 0 VALUE={V(OUT)+V(TRIM7)}
XREQ7 FB7 REF RIPPLE REQC7 COT_REQUEST PARAMS:
+ VLOGIC=5 VSOFT=2m VHYST=4m TDELAY=10.1428571n
EPHASEEN7 PHASEEN7 0 VALUE={V(CTRLEN)*V(ACTIVE7)}
EREQ7 REQ7 0 VALUE={V(REQC7)*V(PERMIT7)*V(PHASEEN7)}
EDENIED7 DENIED7 0 VALUE={V(REQC7)*
+ (1-V(PERMIT7)*V(PHASEEN7))}
XCL7 SENSE7 ILIM TRIP7 COT_CURRENT_LIMIT PARAMS:
+ VLOGIC=5 TDELAY=8.11428571n
ETON7 TONCMD7 0 VALUE={LIMIT(V(TONBASE)*1.01428571,
+ TONMIN,TONMAX)}
XSHOT7 REQ7 TRIP7 TONCMD7 GATE7 READY7 COT_ONESHOT_CMD PARAMS:
+ TONMIN={TONMIN} TONMAX={TONMAX} TOFFMIN={TOFFMIN} VLOGIC=5
XDRV7 GATE7 PHASEEN7 GH7 GL7 COMPLEMENTARY_DRIVER_ENABLE PARAMS:
+ VLOGIC=5 VENHIGH=1 DEAD=20.2857143n
XPH7 IN OUT GH7 GL7 SW7 IMON7 BUCK_PHASE PARAMS:
+ LPH=2.04285714u DCR=9.71428571m RHS=15.2142857m RLS=7.88571429m VBDROP=50m IMONGAIN=1
* Phase 8: normalized mismatch position +1.000000.
ESENSE8 SENSE8 0 VALUE={1.015*V(IMON8)+0.012}
EFB8 FB8 0 VALUE={V(OUT)+V(TRIM8)}
XREQ8 FB8 REF RIPPLE REQC8 COT_REQUEST PARAMS:
+ VLOGIC=5 VSOFT=2m VHYST=4m TDELAY=10.2n
EPHASEEN8 PHASEEN8 0 VALUE={V(CTRLEN)*V(ACTIVE8)}
EREQ8 REQ8 0 VALUE={V(REQC8)*V(PERMIT8)*V(PHASEEN8)}
EDENIED8 DENIED8 0 VALUE={V(REQC8)*
+ (1-V(PERMIT8)*V(PHASEEN8))}
XCL8 SENSE8 ILIM TRIP8 COT_CURRENT_LIMIT PARAMS:
+ VLOGIC=5 TDELAY=8.16n
ETON8 TONCMD8 0 VALUE={LIMIT(V(TONBASE)*1.02,
+ TONMIN,TONMAX)}
XSHOT8 REQ8 TRIP8 TONCMD8 GATE8 READY8 COT_ONESHOT_CMD PARAMS:
+ TONMIN={TONMIN} TONMAX={TONMAX} TOFFMIN={TOFFMIN} VLOGIC=5
XDRV8 GATE8 PHASEEN8 GH8 GL8 COMPLEMENTARY_DRIVER_ENABLE PARAMS:
+ VLOGIC=5 VENHIGH=1 DEAD=20.4n
XPH8 IN OUT GH8 GL8 SW8 IMON8 BUCK_PHASE PARAMS:
+ LPH=2.06u DCR=9.6m RHS=15.3m RLS=7.84m VBDROP=50m IMONGAIN=1
EISUM ISUM 0 VALUE={V(IMON1)+V(IMON2)+V(IMON3)+V(IMON4)+V(IMON5)+V(IMON6)+V(IMON7)+V(IMON8)}
RESR OUT NESR 5m
LESL NESR NCAP 500p
COUT NCAP 0 470u IC=0
RBLEED OUT 0 100
ECAPCURRENT ICAPMON 0 VALUE={V(ISUM)-V(LOADACT)-V(OUT)/100}
.IC V(OUT)=0
.OPTIONS RELTOL=1m ABSTOL=10n VNTOL=1u ITL4=2500
.TRAN 2n 2m 0 2n
.MEAS TRAN STARTUP_MAX MAX V(OUT) FROM=0 TO=400u
.MEAS TRAN LOADSTEP_MIN MIN V(OUT) FROM=400u TO=800u
.MEAS TRAN LINESTEP_MIN MIN V(OUT) FROM=1m TO=1.3m
.MEAS TRAN FINAL_VOUT AVG V(OUT) FROM=1.8m TO=2m
.MEAS TRAN FINAL_ACTIVE AVG V(ACTIVECOUNT) FROM=1.8m TO=2m
.PROBE V(IN) V(OUT) V(NCAP) V(REF) V(ILIM)
+ V(LOADCMD) V(LOADEN) V(LOADACT) V(CTRLEN)
+ V(TONBASE) V(RIPPLE) V(ISUM) V(ICAPMON)
+ V(IMON1) V(SENSE1) V(IAVG1) V(SW1) V(GATE1) V(GH1) V(GL1) V(TONCMD1) V(PERMIT1) V(READY1)
+ V(FB1) V(REQC1) V(REQ1) V(DENIED1) V(TRIP1) V(TRIM1) V(SHAREERR1) V(ACTIVE1)
+ V(IMON2) V(SENSE2) V(IAVG2) V(SW2) V(GATE2) V(GH2) V(GL2) V(TONCMD2) V(PERMIT2) V(READY2)
+ V(FB2) V(REQC2) V(REQ2) V(DENIED2) V(TRIP2) V(TRIM2) V(SHAREERR2) V(ACTIVE2)
+ V(IMON3) V(SENSE3) V(IAVG3) V(SW3) V(GATE3) V(GH3) V(GL3) V(TONCMD3) V(PERMIT3) V(READY3)
+ V(FB3) V(REQC3) V(REQ3) V(DENIED3) V(TRIP3) V(TRIM3) V(SHAREERR3) V(ACTIVE3)
+ V(IMON4) V(SENSE4) V(IAVG4) V(SW4) V(GATE4) V(GH4) V(GL4) V(TONCMD4) V(PERMIT4) V(READY4)
+ V(FB4) V(REQC4) V(REQ4) V(DENIED4) V(TRIP4) V(TRIM4) V(SHAREERR4) V(ACTIVE4)
+ V(IMON5) V(SENSE5) V(IAVG5) V(SW5) V(GATE5) V(GH5) V(GL5) V(TONCMD5) V(PERMIT5) V(READY5)
+ V(FB5) V(REQC5) V(REQ5) V(DENIED5) V(TRIP5) V(TRIM5) V(SHAREERR5) V(ACTIVE5)
+ V(IMON6) V(SENSE6) V(IAVG6) V(SW6) V(GATE6) V(GH6) V(GL6) V(TONCMD6) V(PERMIT6) V(READY6)
+ V(FB6) V(REQC6) V(REQ6) V(DENIED6) V(TRIP6) V(TRIM6) V(SHAREERR6) V(ACTIVE6)
+ V(IMON7) V(SENSE7) V(IAVG7) V(SW7) V(GATE7) V(GH7) V(GL7) V(TONCMD7) V(PERMIT7) V(READY7)
+ V(FB7) V(REQC7) V(REQ7) V(DENIED7) V(TRIP7) V(TRIM7) V(SHAREERR7) V(ACTIVE7)
+ V(IMON8) V(SENSE8) V(IAVG8) V(SW8) V(GATE8) V(GH8) V(GL8) V(TONCMD8) V(PERMIT8) V(READY8)
+ V(FB8) V(REQC8) V(REQ8) V(DENIED8) V(TRIP8) V(TRIM8) V(SHAREERR8) V(ACTIVE8)
+ V(ISHAREAVG) V(ACTIVECOUNT)
.END
