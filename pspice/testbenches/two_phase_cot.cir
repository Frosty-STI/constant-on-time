Constant On-Time Lab -- Stage 7: two-phase fixed-window COT scheduling
.INC "pspice/lib/BUCK_PHASE.lib"
.INC "pspice/lib/COT_ONESHOT.lib"
.INC "pspice/lib/COT_CONTROLLER.lib"
.PARAM VIN_DC=12 VREF_DC=5 TPER=2u TON={TPER*VREF_DC/VIN_DC}
VIN IN 0 {VIN_DC}
VREF REF 0 PWL(0 0 5u 0 6u {VREF_DC})
VRIPPLE RIPPLE 0 0
VILIM ILIM 0 8
XCMP OUT REF RIPPLE REQCOMMON COT_REQUEST PARAMS:
+ VLOGIC=5 VSOFT=2m VHYST=4m TDELAY=10n
* Non-overlapping eligibility windows are an educational scheduler abstraction.
VPERMIT1 PERMIT1 0 PULSE(1 0 900n 1n 1n 1.098u {TPER})
VPERMIT2 PERMIT2 0 PULSE(0 1 1u 1n 1n 900n {TPER})
EREQ1 REQ1 0 VALUE={V(REQCOMMON)*V(PERMIT1)}
EREQ2 REQ2 0 VALUE={V(REQCOMMON)*V(PERMIT2)}
XCL1 IMON1 ILIM TRIP1 COT_CURRENT_LIMIT PARAMS: VLOGIC=5
XCL2 IMON2 ILIM TRIP2 COT_CURRENT_LIMIT PARAMS: VLOGIC=5
XSHOT1 REQ1 TRIP1 GATE1 READY1 COT_ONESHOT PARAMS:
+ TON={TON} TOFFMIN=100n VLOGIC=5
XSHOT2 REQ2 TRIP2 GATE2 READY2 COT_ONESHOT PARAMS:
+ TON={TON} TOFFMIN=100n VLOGIC=5
XDRV1 GATE1 GH1 GL1 COMPLEMENTARY_DRIVER PARAMS: VLOGIC=5 DEAD=20n
XDRV2 GATE2 GH2 GL2 COMPLEMENTARY_DRIVER PARAMS: VLOGIC=5 DEAD=20n
XPH1 IN OUT GH1 GL1 SW1 IMON1 BUCK_PHASE PARAMS:
+ LPH=2u DCR=10m RHS=15m RLS=8m
XPH2 IN OUT GH2 GL2 SW2 IMON2 BUCK_PHASE PARAMS:
+ LPH=2u DCR=10m RHS=15m RLS=8m
RESR OUT NCAP 8m
COUT NCAP 0 330u IC=0
RLOAD OUT 0 500m
RBLEED OUT 0 100
.IC V(OUT)=0
.OPTIONS RELTOL=1m ABSTOL=10n VNTOL=1u ITL4=1500
.TRAN 5n 2m 0 5n
.MEAS TRAN VOUT_AVG AVG V(OUT) FROM=1.8m TO=2m
.MEAS TRAN I1_AVG AVG V(IMON1) FROM=1.8m TO=2m
.MEAS TRAN I2_AVG AVG V(IMON2) FROM=1.8m TO=2m
.MEAS TRAN ISUM_PP PP V(ISUM) FROM=1.8m TO=2m
EISUM ISUM 0 VALUE={V(IMON1)+V(IMON2)}
.PROBE V(OUT) V(SW1) V(SW2) V(IMON1) V(IMON2) V(ISUM)
+ V(REQCOMMON) V(REQ1) V(REQ2) V(GATE1) V(GATE2)
.END
