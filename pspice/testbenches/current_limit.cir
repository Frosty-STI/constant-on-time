Constant On-Time Lab -- COT pulse truncation under per-phase current limit
.INC "pspice/lib/BUCK_PHASE.lib"
.INC "pspice/lib/COT_ONESHOT.lib"
.INC "pspice/lib/COT_CONTROLLER.lib"
.PARAM TPER=2u VREF_DC=5 VIN_DC=12 TON={TPER*VREF_DC/VIN_DC}
VIN IN 0 {VIN_DC}
VREF REF 0 PWL(0 0 5u 0 6u {VREF_DC})
VRIPPLE RIPPLE 0 0
EIS ISENSE 0 VALUE={V(IMON)}
XCOT OUT REF RIPPLE ISENSE GATE REQUEST READY COT_CONTROLLER PARAMS:
+ TON={TON} TOFFMIN=150n ILIMIT=5 ILIMDELAY=10n VLOGIC=5 VSOFT=2m
+ VHYST=4m TDELAY=10n
XDRV GATE GHS GLS COMPLEMENTARY_DRIVER PARAMS: VLOGIC=5 DEAD=20n
XPH IN OUT GHS GLS SW IMON BUCK_PHASE PARAMS: LPH=2u DCR=10m
RESR OUT NCAP 10m
COUT NCAP 0 330u IC=0
* RLOAD draws 2 A at 5 V. A zero-at-start 7 A increment makes demand exceed
* the 5 A model limit after 500 us without an unphysical startup current sink.
RLOAD OUT 0 2.5
ILOADSTEP OUT 0 PULSE(0 7 500u 100n 100n 500u 2m)
RBLEED OUT 0 100
.IC V(OUT)=0
.OPTIONS RELTOL=1m ABSTOL=10n VNTOL=1u ITL4=1500
.TRAN 5n 1.2m 0 5n
.MEAS TRAN IPEAK MAX V(IMON) FROM=500u TO=1m
.MEAS TRAN VLIMIT_MIN MIN V(OUT) FROM=500u TO=1m
.PROBE V(OUT) V(IMON) V(SW) V(GATE) V(REQUEST) V(READY)
+ I(ILOADSTEP)
.END
