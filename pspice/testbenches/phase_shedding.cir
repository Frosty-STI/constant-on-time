Constant On-Time Lab -- two-phase shedding and hysteretic re-entry
.INC "pspice/lib/BUCK_PHASE.lib"
.INC "pspice/lib/COT_ONESHOT.lib"
.INC "pspice/lib/COT_CONTROLLER.lib"
.INC "pspice/lib/PHASE_SHEDDING.lib"
.PARAM VIN_DC=12 VREF_DC=5 TPER=2u TON={TPER*VREF_DC/VIN_DC}
VIN IN 0 {VIN_DC}
VREF REF 0 PWL(0 0 5u 0 6u {VREF_DC})
VRIPPLE RIPPLE 0 0
VFORCE FORCE 0 0
VILIM ILIM 0 8
* LOADMON is the nominal 5 V load-current command used by shed logic.
VLOADMON LOADMON 0 PULSE(1 7 500u 100n 100n 500u 1.4m)
* A 1 A-at-5 V base resistor is safe at startup; the 6 A increment begins only
* at the deliberate load event.
RLOAD OUT 0 5
ILOADSTEP OUT 0 PULSE(0 6 500u 100n 100n 500u 1.4m)
XSHED LOADMON FORCE ACTIVE2 SHEDSTATE PHASE_SHEDDING_2 PARAMS:
+ ISHED=2 IADD=3 TRAMP=20u VLOGIC=1
XCMP OUT REF RIPPLE REQCOMMON COT_REQUEST PARAMS:
+ VLOGIC=5 VSOFT=2m VHYST=4m
VPERMIT1 PERMIT1 0 PULSE(1 0 900n 1n 1n 1.098u {TPER})
VPERMIT2 PERMIT2 0 PULSE(0 1 1u 1n 1n 900n {TPER})
EREQ1 REQ1 0 VALUE={V(REQCOMMON)*V(PERMIT1)}
EREQ2 REQ2 0 VALUE={V(REQCOMMON)*V(PERMIT2)*V(ACTIVE2)}
XCL1 IMON1 ILIM TRIP1 COT_CURRENT_LIMIT PARAMS: VLOGIC=5
XCL2 IMON2 ILIM TRIP2 COT_CURRENT_LIMIT PARAMS: VLOGIC=5
XSHOT1 REQ1 TRIP1 GATE1 READY1 COT_ONESHOT PARAMS:
+ TON={TON} TOFFMIN=100n VLOGIC=5
XSHOT2 REQ2 TRIP2 GATE2 READY2 COT_ONESHOT PARAMS:
+ TON={TON} TOFFMIN=100n VLOGIC=5
XDRV1 GATE1 GH1 GL1 COMPLEMENTARY_DRIVER PARAMS: VLOGIC=5 DEAD=20n
* A disabled synchronous phase must turn both FETs off. Merely forcing PWM low
* would hold its low-side FET on and create a DC path through the inductor.
XDRV2 GATE2 ACTIVE2 GH2 GL2 COMPLEMENTARY_DRIVER_ENABLE PARAMS:
+ VLOGIC=5 VENHIGH=1 DEAD=20n
XPH1 IN OUT GH1 GL1 SW1 IMON1 BUCK_PHASE PARAMS: LPH=2u DCR=10m
XPH2 IN OUT GH2 GL2 SW2 IMON2 BUCK_PHASE PARAMS: LPH=2u DCR=10m
RESR OUT NCAP 8m
COUT NCAP 0 330u IC=0
RBLEED OUT 0 100
EISUM ISUM 0 VALUE={V(IMON1)+V(IMON2)}
.IC V(OUT)=0
.OPTIONS RELTOL=1m ABSTOL=10n VNTOL=1u ITL4=1800
.TRAN 5n 2m 0 5n
.MEAS TRAN VSTEP_MIN MIN V(OUT) FROM=500u TO=700u
.MEAS TRAN VDROP_MAX MAX V(OUT) FROM=1m TO=1.2m
.PROBE V(OUT) V(LOADMON) V(ACTIVE2) V(SHEDSTATE)
+ V(IMON1) V(IMON2) V(ISUM) V(GATE1) V(GATE2)
+ V(GH1) V(GL1) V(GH2) V(GL2) I(ILOADSTEP)
.END
