Constant On-Time Lab -- Stage 3: nonideal synchronous buck with dead time
.INC "pspice/lib/BUCK_PHASE.lib"
.PARAM VIN_DC=12 FSW=500k TPER={1/FSW} DUTY=0.43 TON={DUTY*TPER}
VIN IN 0 {VIN_DC}
VPWM PWM 0 PULSE(0 5 0 2n 2n {TON} {TPER})
XDRV PWM GHS GLS COMPLEMENTARY_DRIVER PARAMS: VLOGIC=5 DEAD=25n
XPH IN OUT GHS GLS SW IMON BUCK_PHASE PARAMS:
+ LPH=2u DCR=12m RHS=18m RLS=9m
RESR OUT NCAP 8m
COUT NCAP 0 220u IC=0
* Resistive startup load avoids an ideal current sink sourcing power at 0 V.
RLOAD OUT 0 1
RBLEED OUT 0 100
.IC V(OUT)=0
.OPTIONS RELTOL=1m ABSTOL=10n VNTOL=1u ITL4=800
.TRAN 5n 800u 0 5n
.MEAS TRAN VOUT_AVG AVG V(OUT) FROM=700u TO=800u
.MEAS TRAN VOUT_PP PP V(OUT) FROM=700u TO=800u
.MEAS TRAN IL_PP PP V(IMON) FROM=700u TO=800u
.MEAS TRAN SW_MIN MIN V(SW) FROM=700u TO=800u
.PROBE V(OUT) V(SW) V(IMON) V(GHS) V(GLS) I(COUT)
.END
