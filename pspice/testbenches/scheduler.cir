Constant On-Time Lab -- isolated two-phase scheduler policy comparison
.INC "pspice/lib/PHASE_SCHEDULER.lib"
* Both phases request together, then phase 2 requests alone.
VREQ1 REQ1 0 PULSE(0 1 1u 10n 10n 9u 20u)
VREQ2 REQ2 0 PULSE(0 1 1u 10n 10n 17u 20u)
VTOKEN TOKEN 0 PULSE(0 1 0 10n 10n 5u 10u)
VINHIBIT INHIBIT 0 PULSE(0 1 14u 10n 10n 2u 40u)
VI1 I1 0 PWL(0 4 8u 4 8.1u 6 30u 6)
VI2 I2 0 PWL(0 5 8u 5 8.1u 3 30u 3)
XRR REQ1 REQ2 TOKEN INHIBIT RRG1 RRG2 RRD1 RRD2
+ ROUND_ROBIN_2 PARAMS: VLOGIC=1
XFE REQ1 REQ2 INHIBIT FEG1 FEG2 FED1 FED2
+ FIRST_ELIGIBLE_2 PARAMS: VLOGIC=1
XCP REQ1 REQ2 I1 I2 INHIBIT CPG1 CPG2 CPD1 CPD2
+ CURRENT_PRIORITY_2 PARAMS: VLOGIC=1 TIEBIAS=50m
.OPTIONS RELTOL=1m ABSTOL=10n VNTOL=1u
.TRAN 5n 30u 0 5n
.PROBE V(REQ1) V(REQ2) V(TOKEN) V(INHIBIT)
+ V(RRG1) V(RRG2) V(RRD1) V(RRD2)
+ V(FEG1) V(FEG2) V(FED1) V(FED2)
+ V(CPG1) V(CPG2) V(CPD1) V(CPD2) V(I1) V(I2)
.END
