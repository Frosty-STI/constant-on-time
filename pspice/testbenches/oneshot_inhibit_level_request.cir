Constant On-Time Lab -- held-request inhibit and off-lock regression fixture
.INC "pspice/lib/COT_ONESHOT.lib"

* REQ rises once and remains high through the entire abort/release sequence.
VREQ REQ 0 PWL(0 0 1u 0 1.001u 5 4u 5)
* Abort both active pulses, then release INHIBIT well before TOFFMIN expires.
VINHIBIT INHIBIT 0 PWL(0 0 1.3u 0 1.301u 5 1.4u 5 1.401u 0 4u 0)
VTONCMD TONCMD 0 800n

XFIX REQ INHIBIT QFIX READYFIX COT_ONESHOT PARAMS:
+ TON=800n TOFFMIN=400n VLOGIC=5 STARTFRAC=0.99
XCMD REQ INHIBIT TONCMD QCMD READYCMD COT_ONESHOT_CMD PARAMS:
+ TONMIN=200n TONMAX=1.2u TOFFMIN=400n VLOGIC=5 STARTFRAC=0.99

.OPTIONS RELTOL=1m ABSTOL=10n VNTOL=1u ITL4=500
.TRAN 500p 2.5u 0 500p

* Acceptance: each RELEASE_TO_READY and RELEASE_TO_REASSERT value is positive;
* READY_TO_REASSERT must be nonnegative. A Q rise before READY would make the
* corresponding target ordering invalid or produce a negative measurement.
.MEAS TRAN FIX_RELEASE_TO_READY TRIG V(INHIBIT) VAL=2.5 FALL=1
+ TARG V(READYFIX) VAL=2.5 RISE=1
.MEAS TRAN FIX_RELEASE_TO_REASSERT TRIG V(INHIBIT) VAL=2.5 FALL=1
+ TARG V(QFIX) VAL=2.5 RISE=2
.MEAS TRAN FIX_READY_TO_REASSERT TRIG V(READYFIX) VAL=2.5 RISE=1
+ TARG V(QFIX) VAL=2.5 RISE=2
.MEAS TRAN CMD_RELEASE_TO_READY TRIG V(INHIBIT) VAL=2.5 FALL=1
+ TARG V(READYCMD) VAL=2.5 RISE=1
.MEAS TRAN CMD_RELEASE_TO_REASSERT TRIG V(INHIBIT) VAL=2.5 FALL=1
+ TARG V(QCMD) VAL=2.5 RISE=2
.MEAS TRAN CMD_READY_TO_REASSERT TRIG V(READYCMD) VAL=2.5 RISE=1
+ TARG V(QCMD) VAL=2.5 RISE=2

.PROBE V(REQ) V(INHIBIT) V(QFIX) V(READYFIX) V(QCMD) V(READYCMD)
.END
