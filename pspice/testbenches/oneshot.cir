Constant On-Time Lab -- isolated fixed-on-time and abort timing fixture
.INC "pspice/lib/COT_ONESHOT.lib"
VREQ REQ 0 PULSE(0 5 1u 1n 1n 100n 4u)
* Abort intersects the second requested pulse.
VINHIBIT INHIBIT 0 PULSE(0 5 5.35u 1n 1n 200n 20u)
XSHOT REQ INHIBIT Q READY COT_ONESHOT PARAMS:
+ TON=800n TOFFMIN=200n VLOGIC=5 STARTFRAC=0.99
.OPTIONS RELTOL=1m ABSTOL=10n VNTOL=1u ITL4=500
.TRAN 1n 12u 0 1n
.MEAS TRAN TON_FIRST TRIG V(Q) VAL=2.5 RISE=1
+ TARG V(Q) VAL=2.5 FALL=1
.MEAS TRAN TOFF_FIRST TRIG V(Q) VAL=2.5 FALL=1
+ TARG V(READY) VAL=2.5 RISE=1
.MEAS TRAN TON_ABORT TRIG V(Q) VAL=2.5 RISE=2
+ TARG V(Q) VAL=2.5 FALL=2
.PROBE V(REQ) V(INHIBIT) V(Q) V(READY)
.END
