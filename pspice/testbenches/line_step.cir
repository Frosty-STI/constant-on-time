Constant On-Time Lab -- adaptive-on-time line-step validation case
.INC "pspice/lib/BUCK_PHASE.lib"
.INC "pspice/lib/COT_ONESHOT.lib"
.INC "pspice/lib/COT_CONTROLLER.lib"
.PARAM TPER=2u VREF_DC=5
VIN IN 0 PULSE(12 9 500u 100n 100n 400u 2m)
VREF REF 0 PWL(0 0 5u 0 6u {VREF_DC})
VRIPPLE RIPPLE 0 0
EIS ISENSE 0 VALUE={V(IMON)}
XCOT IN OUT REF RIPPLE ISENSE GATE REQUEST READY TONMON
+ COT_ADAPTIVE_CONTROLLER PARAMS: TPERIOD={TPER}
+ TONMIN=100n TONMAX=1.5u TOFFMIN=100n ILIMIT=15
+ VLOGIC=5 VSOFT=2m VHYST=4m TDELAY=10n
XDRV GATE GHS GLS COMPLEMENTARY_DRIVER PARAMS: VLOGIC=5 DEAD=20n
XPH IN OUT GHS GLS SW IMON BUCK_PHASE PARAMS: LPH=2u DCR=10m
RESR OUT NCAP 10m
COUT NCAP 0 330u IC=0
RLOAD OUT 0 1
RBLEED OUT 0 100
.IC V(OUT)=0
.OPTIONS RELTOL=1m ABSTOL=10n VNTOL=1u ITL4=1500
.TRAN 5n 1.3m 0 5n
.MEAS TRAN VPRE AVG V(OUT) FROM=450u TO=490u
.MEAS TRAN VLINE_MIN MIN V(OUT) FROM=500u TO=650u
.MEAS TRAN TON_12V AVG V(TONMON) FROM=450u TO=490u
.MEAS TRAN TON_9V AVG V(TONMON) FROM=650u TO=850u
.PROBE V(IN) V(OUT) V(IMON) V(GATE) V(REQUEST) V(TONMON)
.END
