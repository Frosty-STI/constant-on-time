Constant On-Time Lab -- two-phase component mismatch and current balance
.INC "pspice/lib/BUCK_PHASE.lib"
.INC "pspice/lib/COT_ONESHOT.lib"
.INC "pspice/lib/COT_CONTROLLER.lib"
.INC "pspice/lib/CURRENT_BALANCE.lib"
.PARAM VIN_DC=12 VREF_DC=5 TPER=2u TON={TPER*VREF_DC/VIN_DC}
VIN IN 0 {VIN_DC}
VREF REF 0 PWL(0 0 5u 0 6u {VREF_DC})
VRIPPLE RIPPLE 0 0
VENABLE ENABLE 0 1
VILIM ILIM 0 8
ESENSE1 SENSE1 0 VALUE={1.02*V(IMON1)+20m}
ESENSE2 SENSE2 0 VALUE={0.98*V(IMON2)-20m}
XCB SENSE1 SENSE2 ENABLE TRIM1 TRIM2 SHAREERR CURRENT_BALANCE_2 PARAMS:
+ BW=2k KBAL=30m TRIMMAX=80m VLOGIC=1
EFB1 FB1 0 VALUE={V(OUT)+V(TRIM1)}
EFB2 FB2 0 VALUE={V(OUT)+V(TRIM2)}
XCMP1 FB1 REF RIPPLE REQC1 COT_REQUEST PARAMS:
+ VLOGIC=5 VSOFT=2m VHYST=4m
XCMP2 FB2 REF RIPPLE REQC2 COT_REQUEST PARAMS:
+ VLOGIC=5 VSOFT=2m VHYST=4m
VPERMIT1 PERMIT1 0 PULSE(1 0 900n 1n 1n 1.098u {TPER})
VPERMIT2 PERMIT2 0 PULSE(0 1 1u 1n 1n 900n {TPER})
EREQ1 REQ1 0 VALUE={V(REQC1)*V(PERMIT1)}
EREQ2 REQ2 0 VALUE={V(REQC2)*V(PERMIT2)}
XCL1 SENSE1 ILIM TRIP1 COT_CURRENT_LIMIT PARAMS: VLOGIC=5
XCL2 SENSE2 ILIM TRIP2 COT_CURRENT_LIMIT PARAMS: VLOGIC=5
XSHOT1 REQ1 TRIP1 GATE1 READY1 COT_ONESHOT PARAMS:
+ TON={TON} TOFFMIN=100n VLOGIC=5
XSHOT2 REQ2 TRIP2 GATE2 READY2 COT_ONESHOT PARAMS:
+ TON={TON} TOFFMIN=100n VLOGIC=5
XDRV1 GATE1 GH1 GL1 COMPLEMENTARY_DRIVER PARAMS: VLOGIC=5 DEAD=20n
XDRV2 GATE2 GH2 GL2 COMPLEMENTARY_DRIVER PARAMS: VLOGIC=5 DEAD=20n
* Deliberate L, DCR, channel-resistance, and separate sense mismatch.
XPH1 IN OUT GH1 GL1 SW1 IMON1 BUCK_PHASE PARAMS:
+ LPH=1.8u DCR=8m RHS=13m RLS=7m IMONGAIN=1
XPH2 IN OUT GH2 GL2 SW2 IMON2 BUCK_PHASE PARAMS:
+ LPH=2.2u DCR=14m RHS=18m RLS=10m IMONGAIN=1
RESR OUT NCAP 8m
COUT NCAP 0 330u IC=0
RLOAD OUT 0 500m
RBLEED OUT 0 100
EISUM ISUM 0 VALUE={V(IMON1)+V(IMON2)}
.IC V(OUT)=0
.OPTIONS RELTOL=1m ABSTOL=10n VNTOL=1u ITL4=1800
.TRAN 5n 3m 0 5n
.MEAS TRAN I1_AVG AVG V(IMON1) FROM=2.8m TO=3m
.MEAS TRAN I2_AVG AVG V(IMON2) FROM=2.8m TO=3m
.MEAS TRAN SHARE_AVG AVG V(SHAREERR) FROM=2.8m TO=3m
.PROBE V(OUT) V(IMON1) V(IMON2) V(SENSE1) V(SENSE2)
+ V(ISUM) V(SHAREERR)
+ V(TRIM1) V(TRIM2) V(GATE1) V(GATE2)
.END
