Constant On-Time Lab -- Stage 2: ideal single-phase switched buck
.INC "pspice/lib/BUCK_PHASE.lib"
.PARAM VIN_DC=12 VOUT_TARGET=5 FSW=500k TPER={1/FSW}
.PARAM DUTY={VOUT_TARGET/VIN_DC} TON={DUTY*TPER}
VIN IN 0 {VIN_DC}
VPWM PWM 0 PULSE(0 5 0 2n 2n {TON} {TPER})
XDRV PWM GHS GLS COMPLEMENTARY_DRIVER PARAMS: VLOGIC=5 DEAD=5n
XPH IN OUT GHS GLS SW IMON BUCK_PHASE_IDEAL PARAMS: LPH=2u
COUT OUT 0 220u IC=0
RLOAD OUT 0 1
.IC V(OUT)=0
.OPTIONS RELTOL=1m ABSTOL=10n VNTOL=1u ITL4=500
.TRAN 5n 800u 0 5n
.MEAS TRAN VOUT_AVG AVG V(OUT) FROM=700u TO=800u
.MEAS TRAN IL_PP PP V(IMON) FROM=700u TO=800u
.MEAS TRAN SW_PERIOD TRIG V(GHS) VAL=2.5 RISE=350
+ TARG V(GHS) VAL=2.5 RISE=351
.PROBE V(OUT) V(SW) V(IMON) V(GHS) V(GLS)
.END
