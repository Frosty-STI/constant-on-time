Constant On-Time Lab -- COT load-step validation case
.INC "pspice/lib/BUCK_PHASE.lib"
.INC "pspice/lib/COT_ONESHOT.lib"
.INC "pspice/lib/COT_CONTROLLER.lib"
.PARAM TPER=2u VREF_DC=5 VIN_DC=12 TON={TPER*VREF_DC/VIN_DC}
VIN IN 0 {VIN_DC}
VREF REF 0 PWL(0 0 5u 0 6u {VREF_DC})
VRIPPLE RIPPLE 0 0
EIS ISENSE 0 VALUE={V(IMON)}
XCOT OUT REF RIPPLE ISENSE GATE REQUEST READY COT_CONTROLLER PARAMS:
+ TON={TON} TONMIN=100n TONMAX=1.5u TOFFMIN=100n
+ ILIMIT=15 VLOGIC=5 VSOFT=2m VHYST=4m TDELAY=10n
XDRV GATE GHS GLS COMPLEMENTARY_DRIVER PARAMS: VLOGIC=5 DEAD=20n
XPH IN OUT GHS GLS SW IMON BUCK_PHASE PARAMS: LPH=2u DCR=10m
RESR OUT NCAP 10m
COUT NCAP 0 330u IC=0
* RLOAD draws 1 A at 5 V. The incremental ideal load is zero at startup,
* then produces the requested nominal 1 A -> 8 A -> 1 A transient.
RLOAD OUT 0 5
ILOADSTEP OUT 0 PULSE(0 7 500u 100n 100n 400u 2m)
RBLEED OUT 0 100
.IC V(OUT)=0
.OPTIONS RELTOL=1m ABSTOL=10n VNTOL=1u ITL4=1500
.TRAN 5n 1.3m 0 5n
.MEAS TRAN VPRE AVG V(OUT) FROM=450u TO=490u
.MEAS TRAN VMIN MIN V(OUT) FROM=500u TO=650u
.MEAS TRAN VMAX MAX V(OUT) FROM=900u TO=1.05m
.PROBE V(OUT) V(IMON) V(SW) V(GATE) V(REQUEST) I(ILOADSTEP)
.END
