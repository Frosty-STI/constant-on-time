Constant On-Time Lab -- Stage 1: ideal CCM averaged buck
* Run from repository root so pspice/lib paths resolve.
.INC "pspice/lib/BUCK_PHASE.lib"
.PARAM VIN_DC=12 VOUT_TARGET=5 D={VOUT_TARGET/VIN_DC}
.PARAM LPH=2u COUT=220u RLOAD=1
VIN IN 0 {VIN_DC}
VDUTY DUTY 0 {D}
XAVG IN DUTY OUT IMON BUCK_AVERAGED PARAMS: LPH={LPH} DCR=1u
COUT OUT 0 {COUT} IC={VOUT_TARGET}
RLOAD OUT 0 {RLOAD}
EVLMON VLMON 0 VALUE={V(IN)*V(DUTY)-V(OUT)}
.IC V(OUT)={VOUT_TARGET}
.OPTIONS RELTOL=1m ABSTOL=10n VNTOL=1u
.TRAN 20n 500u 0 100n
.MEAS TRAN VOUT_AVG AVG V(OUT) FROM=400u TO=500u
.MEAS TRAN IL_AVG AVG V(IMON) FROM=400u TO=500u
.MEAS TRAN VLBAL AVG V(VLMON) FROM=400u TO=500u
.MEAS TRAN ICBAL AVG I(COUT) FROM=400u TO=500u
.PROBE V(OUT) V(DUTY) V(IMON) V(VLMON)
.END
